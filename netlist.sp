*Simple VCVS Circuit
V1 1 0 10
R1 1 2 1
V2 3 2 1 0 0.5
R2 3 0 1
.end
