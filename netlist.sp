V1 1 0 12
R1 1 2 1k
R2 2 0 2k
R3 2 3 3k
I1 0 3 20m
R4 3 0 4k
V2 3 1 5
.end
