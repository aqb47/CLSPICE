* Golden case 1: 8 nodes, 3 voltage sources, 4 current sources
V1 1 0 18
V2 4 2 5
V3 7 5 12
I1 3 0 2m
I2 0 6 1m
I3 5 1 0.8m
I4 2 7 0.6m
R1 1 2 1k
R2 2 3 2.2k
R3 3 0 1.5k
R4 1 3 3.3k
R5 2 4 4.7k
R6 4 5 2k
R7 5 0 1.2k
R8 3 5 5.6k
R9 1 4 8.2k
R10 4 6 3.9k
R11 6 7 2.7k
R12 7 0 4.3k
R13 6 8 1.8k
R14 8 0 3.6k
R15 5 8 5.1k
R16 2 8 6.4k
.end
