* test circuit
V1 1 0 10
R1 2 1 5
R2 2 0 5
.end
