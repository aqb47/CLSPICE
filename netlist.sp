V1 1 0 12
R1 1 2 1000
R2 2 0 2000
R3 2 3 3000
I1 0 3 0.002
R4 3 0 4000
V2 3 1 5
.end
