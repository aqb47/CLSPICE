V1 1 0 10  * Voltage source of 10V connected between Node 1 and Node 0 (ground)
I1 0 2 2   * Current source of 2A flowing into Node 2 (from Node 0 to Node 2)
R1 1 2 2   * 2-ohm resistor connected between Node 1 and Node 2
R2 2 0 4   * 4-ohm resistor connected between Node 2 and Node 0
V3 1 0 8   * 8-ohm resistor connected between Node 1 and Node 0
.end
