V1 1 0 15
I1 0 2 0.004
R1 1 2 1000
R2 2 3 2000
R3 3 0 1500
V2 3 4 10
R4 4 0 3000
R5 1 4 2500
I2 4 2 0.0025
.end
