* Golden case 5: 16 nodes, benchmark-proven dense network
V1 1 0 30
V2 8 4 10
V3 15 12 -7
I1 0 3 2.2m
I2 6 0 1.1m
I3 10 2 0.9m
I4 13 5 1.5m
I5 8 16 0.8m
I6 4 12 1.0m
I7 11 1 0.6m
R1 1 2 830
R2 2 3 960
R3 3 4 1090
R4 4 5 1220
R5 5 6 1350
R6 6 7 1480
R7 7 8 1610
R8 8 9 1740
R9 9 10 1870
R10 10 11 2000
R11 11 12 2130
R12 12 13 2260
R13 13 14 2390
R14 14 15 2520
R15 15 16 2650
R16 1 3 2040
R17 2 4 2280
R18 3 5 2520
R19 4 6 2760
R20 5 7 3000
R21 6 8 3240
R22 7 9 3480
R23 8 10 3720
R24 9 11 3960
R25 10 12 4200
R26 11 13 4440
R27 12 14 4680
R28 13 15 4920
R29 14 16 5160
R30 2 5 4720
R31 5 8 5630
R32 8 11 6560
R33 11 14 7490
R34 14 0 8420
R35 2 0 4720
R36 5 0 5630
R37 8 0 6560
R38 11 0 7490
R39 14 0 8420
.end
