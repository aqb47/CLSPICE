* test circuit
R1 1 2 10
R2 2 0 20
V1 0 1 10
V2 1 3 50
I1 2 4 10
.end
