* Golden case 4: 14 nodes, 4 voltage sources, 4 current sources
V1 1 0 15
V2 4 2 6
V3 7 5 4
V4 13 11 -3
I1 0 3 1m
I2 5 0 2.2m
I3 6 1 0.7m
I4 10 14 0.5m
R1 1 2 1k
R2 2 3 2k
R3 3 0 1.5k
R4 1 4 3k
R5 4 5 4k
R6 5 0 2.2k
R7 2 5 5k
R8 3 6 3.3k
R9 6 0 2.7k
R10 4 7 1.8k
R11 7 8 2.4k
R12 8 0 3.1k
R13 6 8 4.6k
R14 5 7 6.8k
R15 7 9 5.4k
R16 9 10 2.1k
R17 10 0 3.7k
R18 8 11 6.0k
R19 11 12 4.9k
R20 12 0 2.8k
R21 10 13 7.2k
R22 13 14 1.9k
R23 14 0 4.5k
R24 9 13 5.8k
.end
