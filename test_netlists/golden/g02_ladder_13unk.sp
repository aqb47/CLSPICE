* Golden case 2: 10 nodes, 4 voltage sources, 4 current sources
V1 1 0 24
V2 6 3 7
V3 9 5 4
V4 10 8 -6
I1 2 0 3m
I2 0 4 1.2m
I3 5 1 0.8m
I4 7 9 0.5m
R1 1 2 1.8k
R2 2 3 2.7k
R3 3 0 1k
R4 1 4 3.9k
R5 4 5 2.2k
R6 5 0 4.7k
R7 2 5 6.8k
R8 3 6 1.5k
R9 6 0 2.4k
R10 4 6 3.3k
R11 5 7 2.0k
R12 7 8 3.6k
R13 8 0 1.9k
R14 6 9 4.8k
R15 9 10 2.5k
R16 10 0 5.2k
R17 7 10 6.1k
R18 8 9 7.4k
.end
