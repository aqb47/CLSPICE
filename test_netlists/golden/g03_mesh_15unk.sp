* Golden case 3: 12 nodes, 4 voltage sources, 4 current sources
V1 2 0 12
V2 5 4 9
V3 8 6 -4
V4 12 11 3
I1 0 3 2.5m
I2 7 0 1.1m
I3 10 1 0.9m
I4 9 12 0.7m
R1 1 2 2k
R2 2 3 1.5k
R3 3 4 3.3k
R4 4 0 2.2k
R5 1 5 4.7k
R6 5 6 1.2k
R7 6 0 3.9k
R8 3 6 5.6k
R9 2 7 2.8k
R10 7 0 1.1k
R11 4 7 6.2k
R12 5 8 4.1k
R13 8 9 2.6k
R14 9 0 1.4k
R15 6 10 3.8k
R16 10 11 5.1k
R17 11 0 2.9k
R18 8 12 6.7k
R19 12 0 4.4k
R20 9 12 7.5k
.end
