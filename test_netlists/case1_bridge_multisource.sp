* Case 1: bridge network with mixed sources
V1 1 0 18
V2 4 2 5
I1 3 0 2m
I2 0 5 1m
R1 1 2 1k
R2 2 3 2.2k
R3 3 0 1.5k
R4 1 3 3.3k
R5 2 4 4.7k
R6 4 5 2k
R7 5 0 1.2k
R8 3 5 5.6k
R9 1 4 8.2k
.end
