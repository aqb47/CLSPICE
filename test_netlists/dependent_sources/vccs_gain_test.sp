* Future case: VCCS gain test
* Gname N+ N- NC+ NC- GM
V1 1 0 10
R1 1 2 2k
R2 2 0 1k
G1 2 0 1 0 2m
R3 2 3 3k
R4 3 0 1.5k
G2 3 0 2 0 1.5m
.end
