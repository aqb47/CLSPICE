* Future case: CCVS gain test
* Hname N+ N- Vname transresistance
Vc 1 0 2
V1 2 0 10
R1 2 3 1.5k
R2 3 0 2.5k
H1 3 0 Vc 500
R3 3 4 1.1k
R4 4 0 1.7k
H2 4 0 Vc 250
.end
