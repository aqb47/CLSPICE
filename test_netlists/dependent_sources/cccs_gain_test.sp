* Future case: CCCS gain test
* Fname N+ N- Vname gain
VCTRL 1 0 5
V1 2 0 12
R1 2 3 1k
R2 3 0 2k
F1 3 0 VCTRL 3
R3 3 4 1.5k
R4 4 0 2.2k
F2 4 0 VCTRL 1.5
.end
