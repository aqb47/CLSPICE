* Case 4: dense 7-node test with multiple meshes
V1 1 0 15
V2 4 2 6
V3 7 5 4
I1 0 3 1m
I2 5 0 2.2m
I3 6 1 0.7m
R1 1 2 1k
R2 2 3 2k
R3 3 0 1.5k
R4 1 4 3k
R5 4 5 4k
R6 5 0 2.2k
R7 2 5 5k
R8 3 6 3.3k
R9 6 0 2.7k
R10 4 7 1.8k
R11 7 0 2.4k
R12 6 7 4.6k
R13 5 7 6.8k
.end
