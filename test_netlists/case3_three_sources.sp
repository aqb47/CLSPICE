* Case 3: three voltage sources and distributed current injections
V1 2 0 12
V2 5 4 9
V3 7 1 -4
I1 0 3 2.5m
I2 6 0 1.1m
R1 1 2 2k
R2 2 3 1.5k
R3 3 4 3.3k
R4 4 0 2.2k
R5 1 5 4.7k
R6 5 6 1.2k
R7 6 0 3.9k
R8 3 6 5.6k
R9 2 7 2.8k
R10 7 0 1.1k
R11 4 7 6.2k
.end
