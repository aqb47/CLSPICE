* Case 2: ladder and cross-coupled branches
V1 1 0 24
V2 6 3 7
I1 2 0 3m
I2 0 4 1.2m
I3 5 1 0.8m
R1 1 2 1.8k
R2 2 3 2.7k
R3 3 0 1k
R4 1 4 3.9k
R5 4 5 2.2k
R6 5 0 4.7k
R7 2 5 6.8k
R8 3 6 1.5k
R9 6 0 2.4k
R10 4 6 3.3k
.end
